* Extracted by KLayout with GF180MCU LVS runset on : 16/11/2026 12:26

* cell inverter
.SUBCKT inverter
* cell instance $1 r180 *1 29.925,0.825
X$1 \$2 \$2 \$3 \$2 \$3 \$2 \$3 \$2 \$3 \$2 \$3 \$2 \$4 \$4 \$4 \$4 \$4 \$4 \$4
+ \$4 \$4 \$4 pfet
* cell instance $2 r0 *1 8.65,-0.895
X$2 \$3 via_dev
* cell instance $3 r0 *1 8.65,-4.17
X$3 \$3 via_dev
* cell instance $4 r0 *1 8.65,-4.69
X$4 \$3 via_dev
* cell instance $5 r0 *1 8.65,-5.21
X$5 \$3 via_dev
* cell instance $6 r0 *1 -0.135,-5.475
X$6 SUB \$3 SUB \$3 SUB \$3 SUB \$3 SUB \$3 SUB \$4 \$4 \$4 \$4 \$4 \$4 \$4 \$4
+ \$4 \$4 SUB nfet
* cell instance $7 r0 *1 14.695,-4.17
X$7 \$3 via_dev
* cell instance $8 r0 *1 14.695,-4.69
X$8 \$3 via_dev
* cell instance $9 r0 *1 14.695,-5.21
X$9 \$3 via_dev
* cell instance $10 r0 *1 20.735,-4.17
X$10 \$3 via_dev
* cell instance $11 r0 *1 20.735,-4.69
X$11 \$3 via_dev
* cell instance $12 r0 *1 20.735,-5.21
X$12 \$3 via_dev
* cell instance $13 r0 *1 26.775,-4.17
X$13 \$3 via_dev
* cell instance $14 r0 *1 26.775,-4.69
X$14 \$3 via_dev
* cell instance $15 r0 *1 26.775,-5.21
X$15 \$3 via_dev
* cell instance $16 r0 *1 2.615,-4.17
X$16 \$3 via_dev
* cell instance $17 r0 *1 2.615,-4.69
X$17 \$3 via_dev
* cell instance $18 r0 *1 2.615,-5.21
X$18 \$3 via_dev
* cell instance $19 r0 *1 2.615,0.145
X$19 \$3 via_dev
* cell instance $20 r0 *1 2.615,-0.375
X$20 \$3 via_dev
* cell instance $21 r0 *1 2.615,-0.895
X$21 \$3 via_dev
* cell instance $22 r0 *1 26.775,0.145
X$22 \$3 via_dev
* cell instance $23 r0 *1 26.775,-0.375
X$23 \$3 via_dev
* cell instance $24 r0 *1 26.775,-0.895
X$24 \$3 via_dev
* cell instance $25 r0 *1 20.735,0.145
X$25 \$3 via_dev
* cell instance $26 r0 *1 20.735,-0.375
X$26 \$3 via_dev
* cell instance $27 r0 *1 20.735,-0.895
X$27 \$3 via_dev
* cell instance $28 r0 *1 14.695,0.145
X$28 \$3 via_dev
* cell instance $29 r0 *1 14.695,-0.375
X$29 \$3 via_dev
* cell instance $30 r0 *1 14.695,-0.895
X$30 \$3 via_dev
* cell instance $31 r0 *1 8.65,0.145
X$31 \$3 via_dev
* cell instance $32 r0 *1 8.65,-0.375
X$32 \$3 via_dev
.ENDS inverter

* cell nfet
* pin
* pin
* pin
* pin
* pin
* pin
* pin
* pin
* pin
* pin
* pin
* pin
* pin
* pin
* pin
* pin
* pin
* pin
* pin
* pin
* pin
* pin SUB
.SUBCKT nfet \$2 \$3 \$4 \$5 \$6 \$7 \$8 \$9 \$10 \$11 \$12 \$13 \$14 \$15 \$16
+ \$17 \$18 \$19 \$20 \$21 \$22 SUB
* device instance $1 r0 *1 1.44,1 nfet_03v3
M$1 \$3 \$13 \$2 SUB nfet_03v3 L=2.5U W=2U AS=1.22P AD=0.52P PS=5.22U PD=2.52U
* device instance $2 r0 *1 4.46,1 nfet_03v3
M$2 \$4 \$14 \$3 SUB nfet_03v3 L=2.5U W=2U AS=0.52P AD=0.52P PS=2.52U PD=2.52U
* device instance $3 r0 *1 7.48,1 nfet_03v3
M$3 \$5 \$15 \$4 SUB nfet_03v3 L=2.5U W=2U AS=0.52P AD=0.52P PS=2.52U PD=2.52U
* device instance $4 r0 *1 10.5,1 nfet_03v3
M$4 \$6 \$16 \$5 SUB nfet_03v3 L=2.5U W=2U AS=0.52P AD=0.52P PS=2.52U PD=2.52U
* device instance $5 r0 *1 13.52,1 nfet_03v3
M$5 \$7 \$17 \$6 SUB nfet_03v3 L=2.5U W=2U AS=0.52P AD=0.52P PS=2.52U PD=2.52U
* device instance $6 r0 *1 16.54,1 nfet_03v3
M$6 \$8 \$18 \$7 SUB nfet_03v3 L=2.5U W=2U AS=0.52P AD=0.52P PS=2.52U PD=2.52U
* device instance $7 r0 *1 19.56,1 nfet_03v3
M$7 \$9 \$19 \$8 SUB nfet_03v3 L=2.5U W=2U AS=0.52P AD=0.52P PS=2.52U PD=2.52U
* device instance $8 r0 *1 22.58,1 nfet_03v3
M$8 \$10 \$20 \$9 SUB nfet_03v3 L=2.5U W=2U AS=0.52P AD=0.52P PS=2.52U PD=2.52U
* device instance $9 r0 *1 25.6,1 nfet_03v3
M$9 \$11 \$21 \$10 SUB nfet_03v3 L=2.5U W=2U AS=0.52P AD=0.52P PS=2.52U PD=2.52U
* device instance $10 r0 *1 28.62,1 nfet_03v3
M$10 \$12 \$22 \$11 SUB nfet_03v3 L=2.5U W=2U AS=0.52P AD=1.22P PS=2.52U
+ PD=5.22U
.ENDS nfet

* cell via_dev
* pin
.SUBCKT via_dev \$1
.ENDS via_dev

* cell pfet
* pin
* pin
* pin
* pin
* pin
* pin
* pin
* pin
* pin
* pin
* pin
* pin
* pin
* pin
* pin
* pin
* pin
* pin
* pin
* pin
* pin
* pin
.SUBCKT pfet \$1 \$2 \$3 \$4 \$5 \$6 \$7 \$8 \$9 \$10 \$11 \$12 \$13 \$14 \$15
+ \$16 \$17 \$18 \$19 \$20 \$21 \$22
* device instance $1 r0 *1 1.44,1 pfet_03v3
M$1 \$3 \$13 \$2 \$1 pfet_03v3 L=2.5U W=2U AS=1.3P AD=0.52P PS=5.3U PD=2.52U
* device instance $2 r0 *1 4.46,1 pfet_03v3
M$2 \$4 \$14 \$3 \$1 pfet_03v3 L=2.5U W=2U AS=0.52P AD=0.52P PS=2.52U PD=2.52U
* device instance $3 r0 *1 7.48,1 pfet_03v3
M$3 \$5 \$15 \$4 \$1 pfet_03v3 L=2.5U W=2U AS=0.52P AD=0.52P PS=2.52U PD=2.52U
* device instance $4 r0 *1 10.5,1 pfet_03v3
M$4 \$6 \$16 \$5 \$1 pfet_03v3 L=2.5U W=2U AS=0.52P AD=0.52P PS=2.52U PD=2.52U
* device instance $5 r0 *1 13.52,1 pfet_03v3
M$5 \$7 \$17 \$6 \$1 pfet_03v3 L=2.5U W=2U AS=0.52P AD=0.52P PS=2.52U PD=2.52U
* device instance $6 r0 *1 16.54,1 pfet_03v3
M$6 \$8 \$18 \$7 \$1 pfet_03v3 L=2.5U W=2U AS=0.52P AD=0.52P PS=2.52U PD=2.52U
* device instance $7 r0 *1 19.56,1 pfet_03v3
M$7 \$9 \$19 \$8 \$1 pfet_03v3 L=2.5U W=2U AS=0.52P AD=0.52P PS=2.52U PD=2.52U
* device instance $8 r0 *1 22.58,1 pfet_03v3
M$8 \$10 \$20 \$9 \$1 pfet_03v3 L=2.5U W=2U AS=0.52P AD=0.52P PS=2.52U PD=2.52U
* device instance $9 r0 *1 25.6,1 pfet_03v3
M$9 \$11 \$21 \$10 \$1 pfet_03v3 L=2.5U W=2U AS=0.52P AD=0.52P PS=2.52U PD=2.52U
* device instance $10 r0 *1 28.62,1 pfet_03v3
M$10 \$12 \$22 \$11 \$1 pfet_03v3 L=2.5U W=2U AS=0.52P AD=1.3P PS=2.52U PD=5.3U
.ENDS pfet
