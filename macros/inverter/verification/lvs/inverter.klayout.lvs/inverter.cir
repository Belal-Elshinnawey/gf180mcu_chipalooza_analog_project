* Extracted by KLayout with GF180MCU LVS runset on : 16/11/2026 12:45

.SUBCKT inverter
M$1 \$3 \$4 SUB SUB nfet_03v3 L=2.5U W=2U AS=1.22P AD=0.52P PS=5.22U PD=2.52U
M$2 SUB \$4 \$3 SUB nfet_03v3 L=2.5U W=2U AS=0.52P AD=0.52P PS=2.52U PD=2.52U
M$3 \$3 \$4 SUB SUB nfet_03v3 L=2.5U W=2U AS=0.52P AD=0.52P PS=2.52U PD=2.52U
M$4 SUB \$4 \$3 SUB nfet_03v3 L=2.5U W=2U AS=0.52P AD=0.52P PS=2.52U PD=2.52U
M$5 \$3 \$4 SUB SUB nfet_03v3 L=2.5U W=2U AS=0.52P AD=0.52P PS=2.52U PD=2.52U
M$6 SUB \$4 \$3 SUB nfet_03v3 L=2.5U W=2U AS=0.52P AD=0.52P PS=2.52U PD=2.52U
M$7 \$3 \$4 SUB SUB nfet_03v3 L=2.5U W=2U AS=0.52P AD=0.52P PS=2.52U PD=2.52U
M$8 SUB \$4 \$3 SUB nfet_03v3 L=2.5U W=2U AS=0.52P AD=0.52P PS=2.52U PD=2.52U
M$9 \$3 \$4 SUB SUB nfet_03v3 L=2.5U W=2U AS=0.52P AD=0.52P PS=2.52U PD=2.52U
M$10 SUB \$4 \$3 SUB nfet_03v3 L=2.5U W=2U AS=0.52P AD=1.22P PS=2.52U PD=5.22U
M$11 \$3 \$4 \$2 \$2 pfet_03v3 L=2.5U W=2U AS=1.3P AD=0.52P PS=5.3U PD=2.52U
M$12 \$2 \$4 \$3 \$2 pfet_03v3 L=2.5U W=2U AS=0.52P AD=0.52P PS=2.52U PD=2.52U
M$13 \$3 \$4 \$2 \$2 pfet_03v3 L=2.5U W=2U AS=0.52P AD=0.52P PS=2.52U PD=2.52U
M$14 \$2 \$4 \$3 \$2 pfet_03v3 L=2.5U W=2U AS=0.52P AD=0.52P PS=2.52U PD=2.52U
M$15 \$3 \$4 \$2 \$2 pfet_03v3 L=2.5U W=2U AS=0.52P AD=0.52P PS=2.52U PD=2.52U
M$16 \$2 \$4 \$3 \$2 pfet_03v3 L=2.5U W=2U AS=0.52P AD=0.52P PS=2.52U PD=2.52U
M$17 \$3 \$4 \$2 \$2 pfet_03v3 L=2.5U W=2U AS=0.52P AD=0.52P PS=2.52U PD=2.52U
M$18 \$2 \$4 \$3 \$2 pfet_03v3 L=2.5U W=2U AS=0.52P AD=0.52P PS=2.52U PD=2.52U
M$19 \$3 \$4 \$2 \$2 pfet_03v3 L=2.5U W=2U AS=0.52P AD=0.52P PS=2.52U PD=2.52U
M$20 \$2 \$4 \$3 \$2 pfet_03v3 L=2.5U W=2U AS=0.52P AD=1.3P PS=2.52U PD=5.3U
.ENDS inverter
